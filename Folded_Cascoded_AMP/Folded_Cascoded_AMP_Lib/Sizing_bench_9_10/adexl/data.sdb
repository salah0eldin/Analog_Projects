ADE simulation setup
Run mode: Single Run, Sweeps and Corners
Tests:
  Folded_Cascoded_AMP_Lib:Sizing_bench_9_10:1: Folded_Cascoded_AMP_Lib/Sizing_bench_9_10/schematic, simulator spectre
Global variables:
  Vds = 1
  Vgs = 0
