ADE simulation setup
Run mode: Single Run, Sweeps and Corners
Tests:
  Folded_Cascoded_AMP_Lib:FinalCircuit_Buffer:1: Folded_Cascoded_AMP_Lib/FinalCircuit_Buffer/schematic, simulator spectre
    Outputs: PM; DC-Gain vs Vout
Global variables:
  VIN = 1
