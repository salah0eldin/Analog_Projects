ADE simulation setup
Run mode: Single Run, Sweeps and Corners
Tests:
  Folded_Cascoded_AMP_Lib:Sizing_bench_7_8:1: Folded_Cascoded_AMP_Lib/Sizing_bench_7_8/schematic, simulator spectre
Global variables:
  Vds = 1
  Vgs = 0
