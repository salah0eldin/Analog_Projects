ADE simulation setup
Run mode: Single Run, Sweeps and Corners
Tests:
  Folded_Cascoded_AMP_Lib:Sizing_N_bench:1: Folded_Cascoded_AMP_Lib/Sizing_N_bench/schematic, simulator spectre
    Outputs: id
Global variables:
  Ln = 400n
  Vds = 1.17
  Vgs = 1.17
  Wn = 0.5u
