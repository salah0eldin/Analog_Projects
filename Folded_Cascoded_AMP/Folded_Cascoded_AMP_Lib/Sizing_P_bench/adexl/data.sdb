ADE simulation setup
Run mode: Single Run, Sweeps and Corners
Tests:
  Folded_Cascoded_AMP_Lib:Sizing_P_bench:1: Folded_Cascoded_AMP_Lib/Sizing_P_bench/schematic, simulator spectre
    Outputs: id
Global variables:
  Lp = 400n
  Vds = 1.3
  Vgs = 1.3
  Wp = 0.5u
