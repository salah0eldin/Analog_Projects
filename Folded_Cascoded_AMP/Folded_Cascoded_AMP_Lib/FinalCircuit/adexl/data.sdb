ADE simulation setup
Run mode: Single Run, Sweeps and Corners
Tests:
  Folded_Cascoded_AMP_Lib:FinalCircuit:1: Folded_Cascoded_AMP_Lib/FinalCircuit/schematic, simulator spectre
    Outputs: PM; GM; CMRR; PSRR; v("/VOUT" ?result "dc"); waveVsWave(?x v("/VOUT" ?result "dc") ?y (v("/VOUT" ?result "dc") / VDC("/net4")))
Global variables:
  VICAC = 0
  VICDC = 1.65
  VIDAC = 0
  VIDDC = 0
