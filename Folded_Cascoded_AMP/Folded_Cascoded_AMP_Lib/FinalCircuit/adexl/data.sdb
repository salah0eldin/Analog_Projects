ADE simulation setup
Run mode: Single Run, Sweeps and Corners
Tests:
  Folded_Cascoded_AMP_Lib:FinalCircuit:1: Folded_Cascoded_AMP_Lib/FinalCircuit/schematic, simulator spectre
    Outputs: PM; GM; CMRR; PSRR
Global variables:
  VICAC = 0
  VICDC = 1.65
  VIDAC = 1
  VIDDC = 0
