ADE simulation setup
Run mode: Single Run, Sweeps and Corners
Tests:
  Folded_Cascoded_AMP_Lib:FinalCircuit_Buffer_No_Probe:1: Folded_Cascoded_AMP_Lib/FinalCircuit_Buffer_No_Probe/schematic, simulator spectre
