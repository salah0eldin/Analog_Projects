ADE simulation setup
Run mode: Single Run, Sweeps and Corners
Tests:
  Filter_Approx_Lib:Filter_Approx:1: Filter_Approx_Lib/Filter_Approx/schematic, simulator spectre
    Outputs: VF("/Vout"); VF("/Vo"); Mag; Phase
Global variables:
  C1 = 1p
  C2 = 1p
  C3 = 1p
  C_BW = 0
  H01 = 0.497
  H02 = 0.688
  H03 = 0.36
  Q1 = 3.653
  Q2 = 7.673
  Q3 = 7.678
  R1 = 5625
  R2 = 7785
  R3 = 4072.65
  R_BW = 0
  Vin_AC = 0
  VDD = 1
  GM = 10000
Corners:
  C0 (off): C1=1.15p; C2=1.15p; C3=1.15p
  C1 (off): C1=0.85p; C2=0.85p; C3=0.85p
  C2 (off): C1=1.02p
  C3 (off): C1=0.98p
  C4 (off): GM=1000
  C5 (off): GM=100
  C6: GM=1000; C_BW=1p; R_BW=7957.747
  C7: GM=1000; C_BW=1p; R_BW=79577.47
