ADE simulation setup
Run mode: Single Run, Sweeps and Corners
Tests:
  proj1:Biquad_square:1: proj1/Biquad_square/schematic, simulator spectre
    Outputs: VT("/Vin"); VT("/BPF"); VT("/BSF"); (VT("/BSF") + VT("/BPF"))
Global variables:
  C = 10p
  f = 1M, 5M, 10M
  H0 = 1
  Q = 1.7
  R = 3.183k
