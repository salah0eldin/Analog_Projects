ADE simulation setup
Run mode: Single Run, Sweeps and Corners
Tests:
  proj1:Biquad:1: proj1/Biquad/schematic, simulator spectre
    Outputs: VF("/LPF"); dB20(VF("/HPF")); dB20(VF("/BPF")); dB20(VF("/BSF"))
Global variables:
  C = 10p
  H0 = 1
  Q = 1.7
  R = 3.183k
